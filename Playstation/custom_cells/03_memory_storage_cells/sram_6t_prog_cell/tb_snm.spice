* Static Noise Margin (SNM) & Retention Testbench for 6T SRAM
.include "schematic.spice"

VVDD VDD 0 DC 1.8V
VVSS VSS 0 DC 0.0V
VWL  WL  0 DC 0.0V
VBL  BL  0 DC 1.8V
VBLB BLB 0 DC 1.8V

XDUT WL BL BLB VDD VSS SRAM_6T_CELL

.tran 1ps 4ns
.end
