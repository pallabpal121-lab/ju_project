* =============================================================================
* Full-Custom 8T Dual-Read Single-Write (2R1W) Static Memory Bitcell
* =============================================================================
.subckt BITCELL_8T_2R1W WL_W BL_W BLB_W WL_RA BL_RA WL_RB BL_RB VDD VSS
* 1. 6T Static Core Storage Latch
XM_P1 Q  QB VDD VDD sky130_fd_pr__pfet_01v8 W=0.7u L=0.15u
XM_N1 Q  QB VSS VSS sky130_fd_pr__nfet_01v8 W=1.0u L=0.15u

XM_P2 QB Q  VDD VDD sky130_fd_pr__pfet_01v8 W=0.7u L=0.15u
XM_N2 QB Q  VSS VSS sky130_fd_pr__nfet_01v8 W=1.0u L=0.15u

* 2. Differential Write Pass-Gates (Enabled by WL_W)
XM_W1 BL_W  WL_W Q  VSS sky130_fd_pr__nfet_01v8 W=0.8u L=0.15u
XM_W2 BLB_W WL_W QB VSS sky130_fd_pr__nfet_01v8 W=0.8u L=0.15u

* 3. Decoupled Read Port A Stack (Driven by QB)
XM_RA1 BL_RA WL_RA ND_A VSS sky130_fd_pr__nfet_01v8 W=0.8u L=0.15u
XM_RA2 ND_A  QB    VSS  VSS sky130_fd_pr__nfet_01v8 W=0.8u L=0.15u

* 4. Decoupled Read Port B Stack (Driven by QB)
XM_RB1 BL_RB WL_RB ND_B VSS sky130_fd_pr__nfet_01v8 W=0.8u L=0.15u
XM_RB2 ND_B  QB    VSS  VSS sky130_fd_pr__nfet_01v8 W=0.8u L=0.15u
.ends BITCELL_8T_2R1W
