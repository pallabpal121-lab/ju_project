* =============================================================================
* SCL 180nm (ts18scl) Transistor Model Include for Cadence Spectre
* Target: 1.8V Standard Threshold Voltage CMOS
* =============================================================================

simulator lang=spice

.lib '/home/user17/Synopsys/SCLPDK_V3.0_KIT/scl180/pdk/cdns/sclpdk_v3/HOTCODE/models/ts18scl/v2.0/hspice/ts18sl_scl.lib' tt_18

simulator lang=spectre
