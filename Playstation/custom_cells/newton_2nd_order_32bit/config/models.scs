// =============================================================================
// Cadence Spectre Transistor Model Card (SCL 180nm PDK Include)
// =============================================================================
simulator lang=spice
.lib '/home/user17/Synopsys/SCLPDK_V3.0_KIT/scl180/pdk/cdns/sclpdk_v3/HOTCODE/models/ts18scl/v2.0/hspice/ts18sl_scl.lib' tt_18
simulator lang=spectre
