* =============================================================================
* File: fast_comparator_32b.spice
* Target Technology: SCL 180nm CMOS PDK (ts18scl) / 1.8V Standard Cells
* Description: Transistor-Level Magnitude Comparator Bit-Slice
* =============================================================================

.subckt CMP_BITSLICE A B EQ_BIT GT_BIT VDD VSS
XINV_A A A_B VDD VSS SCL180_INV_1X
XINV_B B B_B VDD VSS SCL180_INV_1X

* EQ_BIT = ~(A ^ B)
XXNOR A A_B B B_B EQ_BIT_B EQ_BIT VDD VSS TG_XOR2

* GT_BIT = A & ~B
XAND A B_B GT_BIT VDD VSS SCL180_AND2
.ends CMP_BITSLICE

.subckt SCL180_INV_1X IN OUT VDD VSS
XM1 OUT IN VDD VDD p18.1 W=1.0u L=0.18u
XM2 OUT IN VSS VSS n18.1 W=0.5u L=0.18u
.ends SCL180_INV_1X

.subckt SCL180_AND2 A B Y VDD VSS
XM1 Y_B A VDD VDD p18.1 W=0.8u L=0.18u
XM2 Y_B B VDD VDD p18.1 W=0.8u L=0.18u
XM3 Y_B A MID VSS n18.1 W=0.6u L=0.18u
XM4 MID B VSS VSS n18.1 W=0.6u L=0.18u
XI1 Y_B Y VDD VSS SCL180_INV_1X
.ends SCL180_AND2

.subckt TG_XOR2 A A_B B B_B OUT OUT_B VDD VSS
XM1 B   A_B OUT VDD p18.1 W=0.8u L=0.18u
XM2 B   A   OUT VSS n18.1 W=0.5u L=0.18u
XM3 B_B A   OUT VDD p18.1 W=0.8u L=0.18u
XM4 B_B A_B OUT VSS n18.1 W=0.5u L=0.18u
XINVO OUT OUT_B VDD VSS SCL180_INV_1X
.ends TG_XOR2
