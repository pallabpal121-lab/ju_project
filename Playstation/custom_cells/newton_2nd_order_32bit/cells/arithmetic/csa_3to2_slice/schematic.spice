* =============================================================================
* File: fused_3input_adder.spice
* Target Technology: SCL 180nm CMOS PDK (ts18scl) / 1.8V Standard Cells
* Description: Transistor-Level Fused 3:2 Carry-Save Slice Cell
* =============================================================================

.subckt CSA_3TO2_SLICE A B C SUM CARRY VDD VSS
* Fast complementary inputs
XINVA A A_B VDD VSS SCL180_INV_1X
XINVB B B_B VDD VSS SCL180_INV_1X
XINVC C C_B VDD VSS SCL180_INV_1X

* SUM = A ^ B ^ C (Two TG XORs)
XXOR1 A A_B B B_B AB AB_B VDD VSS TG_XOR2
XXOR2 AB AB_B C C_B SUM SUM_B VDD VSS TG_XOR2

* CARRY = (A & B) | (B & C) | (A & C) = AB ? C : A (Mux implementation)
XMUX_CARRY C A AB AB_B CARRY VDD VSS TG_MUX2
.ends CSA_3TO2_SLICE

.subckt SCL180_INV_1X IN OUT VDD VSS
XM1 OUT IN VDD VDD p18.1 W=1.0u L=0.18u
XM2 OUT IN VSS VSS n18.1 W=0.5u L=0.18u
.ends SCL180_INV_1X

.subckt TG_XOR2 A A_B B B_B OUT OUT_B VDD VSS
XM1 B   A_B OUT VDD p18.1 W=0.8u L=0.18u
XM2 B   A   OUT VSS n18.1 W=0.5u L=0.18u
XM3 B_B A   OUT VDD p18.1 W=0.8u L=0.18u
XM4 B_B A_B OUT VSS n18.1 W=0.5u L=0.18u
XINVO OUT OUT_B VDD VSS SCL180_INV_1X
.ends TG_XOR2

.subckt TG_MUX2 A B SEL SEL_B OUT VDD VSS
XM1 A SEL_B OUT VDD p18.1 W=0.8u L=0.18u
XM2 A SEL   OUT VSS n18.1 W=0.5u L=0.18u
XM3 B SEL   OUT VDD p18.1 W=0.8u L=0.18u
XM4 B SEL_B OUT VSS n18.1 W=0.5u L=0.18u
.ends TG_MUX2
