* =============================================================================
* File: booth_selector.spice
* Target Technology: SCL 180nm CMOS PDK (ts18scl) / 1.8V Standard Cells
* Description: Full-Custom Transistor-Level Radix-4 Booth Partial Product Selector
* Architecture: 100% Pure Static Complementary CMOS (PUN to VDD, PDN to VSS)
* Compatibility: Cadence Virtuoso IC618 (SpiceIn / schCheck clean) & Spectre
* =============================================================================

.include "../booth_encoder/schematic.spice"

* Note: BOOTH_SELECTOR and all leaf subcircuits (CMOS_AOI22, CMOS_XOR2_CORE,
* SCL180_INV_1X) are fully declared and shared in booth_encoder/schematic.spice
