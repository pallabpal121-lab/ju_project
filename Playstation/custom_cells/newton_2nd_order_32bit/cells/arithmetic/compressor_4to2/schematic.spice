* =============================================================================
* Full-Custom Static Complementary CMOS 4:2 Carry-Save Compressor
* Target Technology: SCL 180nm CMOS PDK (ts18scl) / 1.8V Standard Cells
* Architecture: 100% Pure Static CMOS (PUN to VDD, PDN to VSS, Inputs on Gates)
* Arithmetic: X1 + X2 + X3 + X4 + CIN = 2 * (CARRY + COUT) + SUM
* =============================================================================

.subckt COMPRESSOR_4TO2 X1 X2 X3 X4 CIN SUM CARRY COUT VDD VSS
* Stage 1: Pairwise XOR gates
XXOR1 X1 X2 X12 X12_B VDD VSS CMOS_XOR2
XXOR2 X3 X4 X34 X34_B VDD VSS CMOS_XOR2

* Stage 2: 4-input XOR sum
XXOR3 X12 X34 X1234 X1234_B VDD VSS CMOS_XOR2

* Stage 3: COUT MUX (COUT = X12 ? X3 : X1, completely independent of CIN)
XMUX_COUT X3 X1 X12 COUT VDD VSS CMOS_MUX2

* Stage 4: Final SUM = X1234 ^ CIN
XXOR4 X1234 CIN SUM SUM_B VDD VSS CMOS_XOR2

* Stage 5: CARRY MUX (CARRY = X1234 ? CIN : X4)
XMUX_CARRY CIN X4 X1234 CARRY VDD VSS CMOS_MUX2
.ends COMPRESSOR_4TO2

* =============================================================================
* Pure Static Complementary CMOS Inverter (2 Transistors)
* =============================================================================
.subckt SCL180_INV_1X IN OUT VDD VSS
XM1 OUT IN VDD VDD p18.1 W=1.2u L=0.18u
XM2 OUT IN VSS VSS n18.1 W=0.5u L=0.18u
.ends SCL180_INV_1X

* =============================================================================
* Pure Static Complementary CMOS 2:1 Multiplexer (12 Transistors)
* Logic: OUT = (SEL == 1) ? A : B
* Inputs connect strictly to GATES; PMOS sources to VDD; NMOS sources to VSS
* =============================================================================
.subckt CMOS_MUX2 A B SEL OUT VDD VSS
* Internal Inverter to generate SEL_B
XM_INVS_P SEL_B SEL VDD VDD p18.1 W=1.2u L=0.18u
XM_INVS_N SEL_B SEL VSS VSS n18.1 W=0.5u L=0.18u

* Pull-Up Network (PUN): PMOS connected to VDD rail
* Dual of (A & SEL) | (B & SEL_B) -> (A | SEL) & (B | SEL_B)
XM_P1 N_P1 A     VDD  VDD p18.1 W=1.2u L=0.18u
XM_P2 N_P1 SEL   VDD  VDD p18.1 W=1.2u L=0.18u
XM_P3 OUT_B B     N_P1 VDD p18.1 W=1.2u L=0.18u
XM_P4 OUT_B SEL_B N_P1 VDD p18.1 W=1.2u L=0.18u

* Pull-Down Network (PDN): NMOS connected to VSS rail
* Branch 1: A and SEL
XM_N1 OUT_B A   N_N1 VSS n18.1 W=0.6u L=0.18u
XM_N2 N_N1  SEL VSS  VSS n18.1 W=0.6u L=0.18u
* Branch 2: B and SEL_B
XM_N3 OUT_B B     N_N2 VSS n18.1 W=0.6u L=0.18u
XM_N4 N_N2  SEL_B VSS  VSS n18.1 W=0.6u L=0.18u

* Output Inverter (Inverts OUT_B to provide non-inverted OUT)
XM_OP OUT OUT_B VDD VDD p18.1 W=1.2u L=0.18u
XM_ON OUT OUT_B VSS VSS n18.1 W=0.5u L=0.18u
.ends CMOS_MUX2

* =============================================================================
* Pure Static Complementary CMOS 2-Input XOR/XNOR Gate (12 Transistors)
* Outputs: OUT = A ^ B, OUT_B = ~(A ^ B)
* Inputs connect strictly to GATES; PMOS sources to VDD; NMOS sources to VSS
* =============================================================================
.subckt CMOS_XOR2 A B OUT OUT_B VDD VSS
* Internal Inverters to generate A_B and B_B
XM_IA_P A_B A VDD VDD p18.1 W=1.2u L=0.18u
XM_IA_N A_B A VSS VSS n18.1 W=0.5u L=0.18u
XM_IB_P B_B B VDD VDD p18.1 W=1.2u L=0.18u
XM_IB_N B_B B VSS VSS n18.1 W=0.5u L=0.18u

* Pull-Up Network for XNOR (Node OUT_B):
* Dual of (A & B) | (A_B & B_B) -> (A | B) & (A_B | B_B)
XM_P1 N_P1 A   VDD  VDD p18.1 W=1.2u L=0.18u
XM_P2 N_P1 B   VDD  VDD p18.1 W=1.2u L=0.18u
XM_P3 OUT_B A_B N_P1 VDD p18.1 W=1.2u L=0.18u
XM_P4 OUT_B B_B N_P1 VDD p18.1 W=1.2u L=0.18u

* Pull-Down Network for XNOR (Node OUT_B):
* Branch 1: A & B
XM_N1 OUT_B A VSS_N1 VSS n18.1 W=0.6u L=0.18u
XM_N2 VSS_N1 B VSS   VSS n18.1 W=0.6u L=0.18u
* Branch 2: A_B & B_B
XM_N3 OUT_B A_B VSS_N2 VSS n18.1 W=0.6u L=0.18u
XM_N4 VSS_N2 B_B VSS   VSS n18.1 W=0.6u L=0.18u

* Output Inverter for true XOR output: OUT = ~OUT_B
XM_OP OUT OUT_B VDD VDD p18.1 W=1.2u L=0.18u
XM_ON OUT OUT_B VSS VSS n18.1 W=0.5u L=0.18u
.ends CMOS_XOR2
