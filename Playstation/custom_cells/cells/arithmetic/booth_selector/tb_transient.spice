* =============================================================================
* Transient Analysis for Radix-4 Booth Selector Cell
* =============================================================================
.include "schematic.spice"

VVDD VDD 0 DC 1.8V
VVSS VSS 0 DC 0.0V

* Multiplicand Inputs:
* X_CURR = 1.8V (High), X_PREV = 0.0V (Low)
VX_CURR X_CURR 0 DC 1.8V
VX_PREV X_PREV 0 DC 0.0V

* Control Inputs from Booth Encoder:
* Pulse SINGLE to test 1X selection
VSINGLE SINGLE 0 PULSE(0 1.8 100ps 30ps 30ps 1ns 3ns)
VDOUBLE DOUBLE 0 DC 0.0V
VNEG    NEG    0 DC 0.0V

CL_PPOUT PP_OUT 0 10fF

XDUT X_CURR X_PREV SINGLE DOUBLE NEG PP_OUT VDD VSS BOOTH_SELECTOR

.tran 1ps 6ns
.measure tran tpd_select_single TRIG V(SINGLE) VAL=0.9 RISE=1 TARG V(PP_OUT) VAL=0.9 RISE=1

.end
