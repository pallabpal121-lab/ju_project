* =============================================================================
* File: booth_encoder.spice
* Target Technology: SCL 180nm CMOS PDK (ts18scl) / 1.8V Standard Cells
* Description: Transistor-Level Radix-4 Booth Encoder & Partial Product Selector
* =============================================================================

.subckt BOOTH_ENCODER Y_PLUS Y_CURR Y_PREV SINGLE DOUBLE NEG VDD VSS
* Local Inverters
XINY1 Y_PLUS Y_PLUS_B VDD VSS SCL180_INV_1X
XINY2 Y_CURR Y_CURR_B VDD VSS SCL180_INV_1X
XINY3 Y_PREV Y_PREV_B VDD VSS SCL180_INV_1X

* SINGLE = Y_PREV ^ Y_CURR
XXOR1 Y_PREV Y_PREV_B Y_CURR Y_CURR_B SINGLE SINGLE_B VDD VSS TG_XOR2

* DOUBLE = (Y_PLUS & ~Y_CURR & ~Y_PREV) | (~Y_PLUS & Y_CURR & Y_PREV)
XAND1 Y_PLUS Y_CURR_B Y_PREV_B T1 VDD VSS SCL180_AND3
XAND2 Y_PLUS_B Y_CURR Y_PREV T2 VDD VSS SCL180_AND3
XOR1  T1 T2 DOUBLE VDD VSS SCL180_OR2

* NEG = Y_PLUS & (~Y_CURR | ~Y_PREV)
XNAND1 Y_CURR Y_PREV NAND12 VDD VSS SCL180_NAND2
XAND3  Y_PLUS NAND12 NEG VDD VSS SCL180_AND2
.ends BOOTH_ENCODER

.subckt BOOTH_SELECTOR X_CURR X_PREV SINGLE DOUBLE NEG PP_OUT VDD VSS
* Selects between 0, X, 2*X (X_PREV) and inverts if NEG=1
XINV_NEG NEG NEG_B VDD VSS SCL180_INV_1X
XMUX_MAG X_PREV X_CURR DOUBLE SINGLE MAG VDD VSS TG_MUX2
* Conditional Invert via XOR with NEG
XXOR_NEG MAG MAG_B NEG NEG_B PP_OUT PP_OUT_B VDD VSS TG_XOR2
.ends BOOTH_SELECTOR

* Basic Standard Gate Subcircuits
.subckt SCL180_INV_1X IN OUT VDD VSS
XM1 OUT IN VDD VDD p18.1 W=1.0u L=0.18u
XM2 OUT IN VSS VSS n18.1 W=0.5u L=0.18u
.ends SCL180_INV_1X

.subckt SCL180_AND2 A B Y VDD VSS
XN1 A B Y_B VDD VSS SCL180_NAND2
XI1 Y_B Y VDD VSS SCL180_INV_1X
.ends SCL180_AND2

.subckt SCL180_NAND2 A B Y VDD VSS
XM1 Y A VDD VDD p18.1 W=0.8u L=0.18u
XM2 Y B VDD VDD p18.1 W=0.8u L=0.18u
XM3 Y A MID VSS n18.1 W=0.6u L=0.18u
XM4 MID B VSS VSS n18.1 W=0.6u L=0.18u
.ends SCL180_NAND2

.subckt SCL180_OR2 A B Y VDD VSS
XM1 MID A VDD VDD p18.1 W=1.0u L=0.18u
XM2 Y_B B MID VDD p18.1 W=1.0u L=0.18u
XM3 Y_B A VSS VSS n18.1 W=0.5u L=0.18u
XM4 Y_B B VSS VSS n18.1 W=0.5u L=0.18u
XI1 Y_B Y VDD VSS SCL180_INV_1X
.ends SCL180_OR2

.subckt SCL180_AND3 A B C Y VDD VSS
XM1 Y_B A VDD VDD p18.1 W=0.8u L=0.18u
XM2 Y_B B VDD VDD p18.1 W=0.8u L=0.18u
XM3 Y_B C VDD VDD p18.1 W=0.8u L=0.18u
XM4 Y_B A N1 VSS n18.1 W=0.7u L=0.18u
XM5 N1 B N2 VSS n18.1 W=0.7u L=0.18u
XM6 N2 C VSS VSS n18.1 W=0.7u L=0.18u
XI1 Y_B Y VDD VSS SCL180_INV_1X
.ends SCL180_AND3

.subckt TG_XOR2 A A_B B B_B OUT OUT_B VDD VSS
XM1 B   A_B OUT VDD p18.1 W=0.8u L=0.18u
XM2 B   A   OUT VSS n18.1 W=0.5u L=0.18u
XM3 B_B A   OUT VDD p18.1 W=0.8u L=0.18u
XM4 B_B A_B OUT VSS n18.1 W=0.5u L=0.18u
XINVO OUT OUT_B VDD VSS SCL180_INV_1X
.ends TG_XOR2

.subckt TG_MUX2 A B SEL SEL_B OUT VDD VSS
XM1 A SEL_B OUT VDD p18.1 W=0.8u L=0.18u
XM2 A SEL   OUT VSS n18.1 W=0.5u L=0.18u
XM3 B SEL   OUT VDD p18.1 W=0.8u L=0.18u
XM4 B SEL_B OUT VSS n18.1 W=0.5u L=0.18u
.ends TG_MUX2
