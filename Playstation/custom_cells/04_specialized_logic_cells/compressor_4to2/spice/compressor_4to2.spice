* =============================================================================
* File: compressor_4to2.spice
* Target Technology: SkyWater 130nm (sky130_fd_pr) / 1.8V Standard Cells
* Description: Transistor-Level 4:2 Carry-Save Compressor Subcircuit
* Total Transistors: 44 MOSFETs (Transmission Gate / PTL Architecture)
* =============================================================================

.subckt COMPRESSOR_4TO2 X1 X2 X3 X4 CIN SUM CARRY COUT VDD VSS
* -----------------------------------------------------------------------------
* Subcircuit Inverters for complementary inputs
* -----------------------------------------------------------------------------
XINV1 X1 X1_B VDD VSS SKY130_INV_1X
XINV2 X2 X2_B VDD VSS SKY130_INV_1X
XINV3 X3 X3_B VDD VSS SKY130_INV_1X
XINV4 X4 X4_B VDD VSS SKY130_INV_1X
XINVC CIN CIN_B VDD VSS SKY130_INV_1X

* -----------------------------------------------------------------------------
* Stage 1: Fast TG XORs (X1^X2) and (X3^X4)
* -----------------------------------------------------------------------------
XXOR1 X1 X1_B X2 X2_B X12 X12_B VDD VSS TG_XOR2
XXOR2 X3 X3_B X4 X4_B X34 X34_B VDD VSS TG_XOR2

* -----------------------------------------------------------------------------
* Stage 2: Fast TG XOR (X12^X34)
* -----------------------------------------------------------------------------
XXOR3 X12 X12_B X34 X34_B X1234 X1234_B VDD VSS TG_XOR2

* -----------------------------------------------------------------------------
* Stage 3: COUT Multiplexer: COUT = X12 ? X3 : X1
* -----------------------------------------------------------------------------
XMUX_COUT X3 X1 X12 X12_B COUT VDD VSS TG_MUX2

* -----------------------------------------------------------------------------
* Stage 4: SUM XOR: SUM = X1234 ^ CIN
* -----------------------------------------------------------------------------
XXOR4 X1234 X1234_B CIN CIN_B SUM SUM_B VDD VSS TG_XOR2

* -----------------------------------------------------------------------------
* Stage 5: CARRY Multiplexer: CARRY = X1234 ? CIN : X4
* -----------------------------------------------------------------------------
XMUX_CARRY CIN X4 X1234 X1234_B CARRY VDD VSS TG_MUX2

.ends COMPRESSOR_4TO2

* =============================================================================
* Low-Level Cell Primitives
* =============================================================================
.subckt SKY130_INV_1X IN OUT VDD VSS
XM1 OUT IN VDD VDD sky130_fd_pr__pfet_01v8 W=1.0u L=0.15u
XM2 OUT IN VSS VSS sky130_fd_pr__nfet_01v8 W=0.5u L=0.15u
.ends SKY130_INV_1X

.subckt TG_MUX2 A B SEL SEL_B OUT VDD VSS
* Pass A when SEL=1, SEL_B=0
XM1 A SEL_B OUT VDD sky130_fd_pr__pfet_01v8 W=0.8u L=0.15u
XM2 A SEL   OUT VSS sky130_fd_pr__nfet_01v8 W=0.5u L=0.15u
* Pass B when SEL=0, SEL_B=1
XM3 B SEL   OUT VDD sky130_fd_pr__pfet_01v8 W=0.8u L=0.15u
XM4 B SEL_B OUT VSS sky130_fd_pr__nfet_01v8 W=0.5u L=0.15u
.ends TG_MUX2

.subckt TG_XOR2 A A_B B B_B OUT OUT_B VDD VSS
* Fast 6-transistor Transmission Gate XOR
XM1 B   A_B OUT VDD sky130_fd_pr__pfet_01v8 W=0.8u L=0.15u
XM2 B   A   OUT VSS sky130_fd_pr__nfet_01v8 W=0.5u L=0.15u
XM3 B_B A   OUT VDD sky130_fd_pr__pfet_01v8 W=0.8u L=0.15u
XM4 B_B A_B OUT VSS sky130_fd_pr__nfet_01v8 W=0.5u L=0.15u
XINVO OUT OUT_B VDD VSS SKY130_INV_1X
.ends TG_XOR2
