* =============================================================================
* File: tg_mux.spice
* Target Technology: SkyWater 130nm (sky130_fd_pr) / 1.8V Standard Cells
* Description: Transistor-Level Transmission Gate Multiplexer Subcircuits
* =============================================================================

.subckt TG_MUX2_1BIT IN0 IN1 SEL SEL_B OUT VDD VSS
XM_TG0_P IN0 SEL   OUT VDD sky130_fd_pr__pfet_01v8 W=1.0u L=0.15u
XM_TG0_N IN0 SEL_B OUT VSS sky130_fd_pr__nfet_01v8 W=0.6u L=0.15u

XM_TG1_P IN1 SEL_B OUT VDD sky130_fd_pr__pfet_01v8 W=1.0u L=0.15u
XM_TG1_N IN1 SEL   OUT VSS sky130_fd_pr__nfet_01v8 W=0.6u L=0.15u
.ends TG_MUX2_1BIT

.subckt TG_MUX4_1BIT IN0 IN1 IN2 IN3 S0 S0_B S1 S1_B OUT VDD VSS
* Stage 1: Two 2:1 muxes controlled by S0
XMUX0 IN0 IN1 S0 S0_B M0 VDD VSS TG_MUX2_1BIT
XMUX1 IN2 IN3 S0 S0_B M1 VDD VSS TG_MUX2_1BIT
* Stage 2: One 2:1 mux controlled by S1
XMUX2 M0  M1  S1 S1_B OUT VDD VSS TG_MUX2_1BIT
.ends TG_MUX4_1BIT
