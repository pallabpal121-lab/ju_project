// =============================================================================
// Cadence Spectre Transistor Model Card
// =============================================================================
simulator lang=spectre

// 1.8V NMOS Device Model
model sky130_fd_pr__nfet_01v8 mos1 type=n \
    vto=0.45 tox=4.1e-9 u0=500.0 kp=170e-6 lambda=0.05 \
    gamma=0.4 phi=0.65 cgso=2.5e-10 cgdo=2.5e-10

// 1.8V PMOS Device Model
model sky130_fd_pr__pfet_01v8 mos1 type=p \
    vto=-0.45 tox=4.1e-9 u0=200.0 kp=70e-6 lambda=0.05 \
    gamma=0.4 phi=0.65 cgso=2.5e-10 cgdo=2.5e-10
